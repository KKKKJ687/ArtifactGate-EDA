* software-only ngspice fixture 14
R1 in out 1014
C1 out 0 1u
.end
