* software-only ngspice fixture 24
R1 in out 1024
C1 out 0 1u
.end
