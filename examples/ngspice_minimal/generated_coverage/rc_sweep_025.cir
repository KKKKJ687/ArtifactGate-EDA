* software-only ngspice fixture 25
R1 in out 1025
C1 out 0 1u
.end
