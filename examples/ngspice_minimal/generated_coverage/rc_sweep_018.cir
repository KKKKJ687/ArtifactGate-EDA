* software-only ngspice fixture 18
R1 in out 1018
C1 out 0 1u
.end
