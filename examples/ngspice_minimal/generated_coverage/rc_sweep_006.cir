* software-only ngspice fixture 6
R1 in out 1006
C1 out 0 1u
.end
