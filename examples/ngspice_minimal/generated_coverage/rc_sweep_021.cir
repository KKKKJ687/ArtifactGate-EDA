* software-only ngspice fixture 21
R1 in out 1021
C1 out 0 1u
.end
