* software-only ngspice fixture 22
R1 in out 1022
C1 out 0 1u
.end
