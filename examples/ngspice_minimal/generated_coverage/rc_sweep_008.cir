* software-only ngspice fixture 8
R1 in out 1008
C1 out 0 1u
.end
