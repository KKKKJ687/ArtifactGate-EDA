* software-only ngspice fixture 23
R1 in out 1023
C1 out 0 1u
.end
