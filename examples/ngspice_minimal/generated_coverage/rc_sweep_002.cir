* software-only ngspice fixture 2
R1 in out 1002
C1 out 0 1u
.end
