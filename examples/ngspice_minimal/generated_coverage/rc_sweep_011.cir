* software-only ngspice fixture 11
R1 in out 1011
C1 out 0 1u
.end
