* software-only ngspice fixture 20
R1 in out 1020
C1 out 0 1u
.end
