* software-only ngspice fixture 9
R1 in out 1009
C1 out 0 1u
.end
