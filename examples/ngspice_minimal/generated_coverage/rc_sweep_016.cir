* software-only ngspice fixture 16
R1 in out 1016
C1 out 0 1u
.end
