* software-only ngspice fixture 3
R1 in out 1003
C1 out 0 1u
.end
