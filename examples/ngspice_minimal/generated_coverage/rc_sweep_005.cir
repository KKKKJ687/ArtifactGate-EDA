* software-only ngspice fixture 5
R1 in out 1005
C1 out 0 1u
.end
