* software-only ngspice fixture 17
R1 in out 1017
C1 out 0 1u
.end
