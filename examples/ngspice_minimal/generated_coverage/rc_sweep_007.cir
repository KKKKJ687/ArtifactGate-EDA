* software-only ngspice fixture 7
R1 in out 1007
C1 out 0 1u
.end
