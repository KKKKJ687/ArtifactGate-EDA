* software-only ngspice fixture 10
R1 in out 1010
C1 out 0 1u
.end
